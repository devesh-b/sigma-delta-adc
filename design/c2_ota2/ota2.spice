* OTA2 (generated by design/c2_ota2/netlist_ota2.py from sizes_ota2.py via c1_ota1/netlist.py; cmfb=sc, mut=None, chop=False, vt=no) - do not edit. Bias nets are inputs (OTA1's).
.subckt ota2 vdd vss inp inn outp outn vicm vocm ibtp ibn ibp ivbnc ivbpc ivbl0 chp chn chlp chln isl ph1 ph1b ph2 ph2b rstb
XSisl1 inp isl vicm vss sky130_fd_pr__nfet_g5v0d10v5 w=2 l=0.5 m=1 ad=0.58 as=0.58 pd=4.58 ps=4.58
XSisl2 inn isl vicm vss sky130_fd_pr__nfet_g5v0d10v5 w=2 l=0.5 m=1 ad=0.58 as=0.58 pd=4.58 ps=4.58
Xmt tail ibtp vdd vdd sky130_fd_pr__pfet_g5v0d10v5 w=3.75 l=6 m=18 ad=1.087 as=1.087 pd=8.08 ps=8.08
Xmin1 da gp tail tail sky130_fd_pr__pfet_01v8 w=10 l=0.5 m=7 ad=2.9 as=2.9 pd=20.58 ps=20.58
Xmin2 db gm tail tail sky130_fd_pr__pfet_01v8 w=10 l=0.5 m=7 ad=2.9 as=2.9 pd=20.58 ps=20.58
Xmpp1 fa vss da da sky130_fd_pr__pfet_g5v0d10v5 w=5.625 l=0.5 m=1 ad=1.631 as=1.631 pd=11.83 ps=11.83
Xmpp2 fb vss db db sky130_fd_pr__pfet_g5v0d10v5 w=5.625 l=0.5 m=1 ad=1.631 as=1.631 pd=11.83 ps=11.83
Xmn1 fa ibn vss vss sky130_fd_pr__nfet_g5v0d10v5 w=2.25 l=8 m=18 ad=0.6525 as=0.6525 pd=5.08 ps=5.08
Xmn2 fb ibn vss vss sky130_fd_pr__nfet_g5v0d10v5 w=2.25 l=8 m=18 ad=0.6525 as=0.6525 pd=5.08 ps=5.08
Xmnc1 outn ivbnc xa vss sky130_fd_pr__nfet_g5v0d10v5 w=5.625 l=2 m=2 ad=1.631 as=1.631 pd=11.83 ps=11.83
Xmnc2 outp ivbnc xb vss sky130_fd_pr__nfet_g5v0d10v5 w=5.625 l=2 m=2 ad=1.631 as=1.631 pd=11.83 ps=11.83
Xmpc1 outn ivbpc sa sa sky130_fd_pr__pfet_g5v0d10v5 w=5 l=2 m=9 ad=1.45 as=1.45 pd=10.58 ps=10.58
Xmpc2 outp ivbpc sb sb sky130_fd_pr__pfet_g5v0d10v5 w=5 l=2 m=9 ad=1.45 as=1.45 pd=10.58 ps=10.58
Xmpl1 sa ibp vdd vdd sky130_fd_pr__pfet_g5v0d10v5 w=2.5 l=4 m=18 ad=0.725 as=0.725 pd=5.58 ps=5.58
Xmpl2 sb ibp vdd vdd sky130_fd_pr__pfet_g5v0d10v5 w=2.5 l=4 m=18 ad=0.725 as=0.725 pd=5.58 ps=5.58
Xmplc1 sa ctl vdd vdd sky130_fd_pr__pfet_g5v0d10v5 w=2.1 l=2 m=4 ad=0.609 as=0.609 pd=4.78 ps=4.78
Xmplc2 sb ctl vdd vdd sky130_fd_pr__pfet_g5v0d10v5 w=2.1 l=2 m=4 ad=0.609 as=0.609 pd=4.78 ps=4.78
Ccp outp ctl 1e-13
Ccn outn ctl 1e-13
Xmrst ctl rstb ivbl0 vdd sky130_fd_pr__pfet_g5v0d10v5 w=1 l=0.5 m=1 ad=0.29 as=0.29 pd=2.58 ps=2.58
Xmrsb bli rstb ivbl0 vdd sky130_fd_pr__pfet_g5v0d10v5 w=1 l=0.5 m=1 ad=0.29 as=0.29 pd=2.58 ps=2.58
Xmrin rst rstb vss vss sky130_fd_pr__nfet_g5v0d10v5 w=0.42 l=0.5 m=1 ad=0.1218 as=0.1218 pd=1.42 ps=1.42
Xmrip rst rstb vdd vdd sky130_fd_pr__pfet_g5v0d10v5 w=0.84 l=0.5 m=1 ad=0.2436 as=0.2436 pd=2.26 ps=2.26
Xmrsopn outp rst vocm vss sky130_fd_pr__nfet_g5v0d10v5 w=2 l=0.5 m=1 ad=0.58 as=0.58 pd=4.58 ps=4.58
Xmrsonn outn rst vocm vss sky130_fd_pr__nfet_g5v0d10v5 w=2 l=0.5 m=1 ad=0.58 as=0.58 pd=4.58 ps=4.58
Xmrsopp outp rstb vocm vdd sky130_fd_pr__pfet_g5v0d10v5 w=4 l=0.5 m=1 ad=1.16 as=1.16 pd=8.58 ps=8.58
Xmrsonp outn rstb vocm vdd sky130_fd_pr__pfet_g5v0d10v5 w=4 l=0.5 m=1 ad=1.16 as=1.16 pd=8.58 ps=8.58
Xmit cit ibn vss vss sky130_fd_pr__nfet_g5v0d10v5 w=2.25 l=8 m=1 ad=0.6525 as=0.6525 pd=5.08 ps=5.08
Xmia1 cid ctl cit vss sky130_fd_pr__nfet_g5v0d10v5 w=2.5 l=14 m=2 ad=0.725 as=0.725 pd=5.58 ps=5.58
Xmia2 bli bli cit vss sky130_fd_pr__nfet_g5v0d10v5 w=2.5 l=14 m=2 ad=0.725 as=0.725 pd=5.58 ps=5.58
Xmil1 cid cid vdd vdd sky130_fd_pr__pfet_g5v0d10v5 w=3 l=16 m=2 ad=0.87 as=0.87 pd=6.58 ps=6.58
Xmil2 bli cid vdd vdd sky130_fd_pr__pfet_g5v0d10v5 w=3 l=16 m=2 ad=0.87 as=0.87 pd=6.58 ps=6.58
Cint bli vdd 2e-12
Crp rap rbp 5e-14
XSr1apn rap ph1 vocm vss sky130_fd_pr__nfet_g5v0d10v5 w=1 l=0.5 m=1 ad=0.29 as=0.29 pd=2.58 ps=2.58
XSr1app rap ph1b vocm vdd sky130_fd_pr__pfet_g5v0d10v5 w=2 l=0.5 m=1 ad=0.58 as=0.58 pd=4.58 ps=4.58
XSr1bpn rbp ph1 bli vss sky130_fd_pr__nfet_g5v0d10v5 w=1 l=0.5 m=1 ad=0.29 as=0.29 pd=2.58 ps=2.58
XSr1bpp rbp ph1b bli vdd sky130_fd_pr__pfet_g5v0d10v5 w=2 l=0.5 m=1 ad=0.58 as=0.58 pd=4.58 ps=4.58
XSr2apn rap ph2 outp vss sky130_fd_pr__nfet_g5v0d10v5 w=1 l=0.5 m=1 ad=0.29 as=0.29 pd=2.58 ps=2.58
XSr2app rap ph2b outp vdd sky130_fd_pr__pfet_g5v0d10v5 w=2 l=0.5 m=1 ad=0.58 as=0.58 pd=4.58 ps=4.58
XSr2bpn rbp ph2 ctl vss sky130_fd_pr__nfet_g5v0d10v5 w=1 l=0.5 m=1 ad=0.29 as=0.29 pd=2.58 ps=2.58
XSr2bpp rbp ph2b ctl vdd sky130_fd_pr__pfet_g5v0d10v5 w=2 l=0.5 m=1 ad=0.58 as=0.58 pd=4.58 ps=4.58
Crn ran rbn 5e-14
XSr1ann ran ph1 vocm vss sky130_fd_pr__nfet_g5v0d10v5 w=1 l=0.5 m=1 ad=0.29 as=0.29 pd=2.58 ps=2.58
XSr1anp ran ph1b vocm vdd sky130_fd_pr__pfet_g5v0d10v5 w=2 l=0.5 m=1 ad=0.58 as=0.58 pd=4.58 ps=4.58
XSr1bnn rbn ph1 bli vss sky130_fd_pr__nfet_g5v0d10v5 w=1 l=0.5 m=1 ad=0.29 as=0.29 pd=2.58 ps=2.58
XSr1bnp rbn ph1b bli vdd sky130_fd_pr__pfet_g5v0d10v5 w=2 l=0.5 m=1 ad=0.58 as=0.58 pd=4.58 ps=4.58
XSr2ann ran ph2 outn vss sky130_fd_pr__nfet_g5v0d10v5 w=1 l=0.5 m=1 ad=0.29 as=0.29 pd=2.58 ps=2.58
XSr2anp ran ph2b outn vdd sky130_fd_pr__pfet_g5v0d10v5 w=2 l=0.5 m=1 ad=0.58 as=0.58 pd=4.58 ps=4.58
XSr2bnn rbn ph2 ctl vss sky130_fd_pr__nfet_g5v0d10v5 w=1 l=0.5 m=1 ad=0.29 as=0.29 pd=2.58 ps=2.58
XSr2bnp rbn ph2b ctl vdd sky130_fd_pr__pfet_g5v0d10v5 w=2 l=0.5 m=1 ad=0.58 as=0.58 pd=4.58 ps=4.58
Vwi1 inp gp 0
Vwi2 inn gm 0
Vwf1 fa xa 0
Vwf2 fb xb 0
.ends ota2
